x1 VDD v_in v_out 0 subckt-rc
Vdd VDD 0 1.5
Vin v_in 0 pulse (0 1.5 10n 0.5n 0.5n 10n 2)
C1 v_out 0 1e-15
R1 v_out 0 1e9

.subckt subckt-rc VDD v_ai v_ao VSS
*.ipin v_ai
*.opin v_ao
*.ipin VDD
*.ipin VSS

C1 v_ao VSS 10e-15
R1 v_ai v_ao 10e3

.ends

.end
