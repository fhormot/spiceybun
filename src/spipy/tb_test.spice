* Control statements added by the tool
.param t_edge=
.param c_load=
.param v_vdd=

.control
		tran 1e-11  500e-9 0 100e-12

		set wr_vecnames
		set wr_singlescale
		wrdata /home/fhormot/wk/xschem/spipy/src/spipy/output.raw

		* Measurements

	exit
.endc

.end
