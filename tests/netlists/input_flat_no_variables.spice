x1 VDD v_in v_out 0 subckt-rc
Vdd VDD 0 1.5
Vin v_in 0 pulse (0 1.5 10n 0.5n 0.5n 10n 2)
C1 v_out 0 1e-15
R1 V-out 0 1e12

.subckt subckt-rc VDD v_ai v_o VSS
*.ipin v_ai
*.opin v_o
*.ipin VDD
*.ipin VSS

*C1 v_o VSS 10e-15
R1 v_i v_o 10e3

.ends

.end
